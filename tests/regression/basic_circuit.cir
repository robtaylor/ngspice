Basic Resistor Circuit Test
* Simple circuit to test ngspice functionality

V1 1 0 DC 5V
R1 1 2 1k
R2 2 0 2k

.OP
.PRINT V(1) V(2) I(V1)
.END
